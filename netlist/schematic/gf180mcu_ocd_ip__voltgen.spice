** sch_path: /home/tim/gits/gf180mcu_ocd_chipalooza/dependencies/gf180mcu_ocd_ip__biasgen/xschem/gf180mcu_ocd_ip__voltgen.sch
.subckt gf180mcu_ocd_ip__voltgen dvdd dvss vdd s[2] s[1] s[0] vbg vss ibias1u_1 vout_buf ibias1u_2 ena vout_unbuf ena1 ena2 high
+ vgen_ena2_h
*.PININFO vdd:B vss:B vbg:I vout_unbuf:O ibias1u_1:B s[2:0]:I dvdd:B dvss:B ena:I vout_buf:O ibias1u_2:B ena1:I ena2:I high:I
*+ vgen_ena2_h:O
x2 v7b vdd vref7 vout_unbuf vss v7 xgate
x3 vdd v0 v0b vss hv_inv_1
x4 v6b vdd vref6 vout_unbuf vss v6 xgate
x5 v5b vdd vref5 vout_unbuf vss v5 xgate
x6 v4b vdd vref4 vout_unbuf vss v4 xgate
x7 v3b vdd vref3 vout_unbuf vss v3 xgate
x8 v2b vdd vref2 vout_unbuf vss v2 xgate
x9 v1b vdd vref1 vout_unbuf vss v1 xgate
x10 v0b vdd vref0 vout_unbuf vss v0 xgate
x11 net2 net1 v0 vdd vss level_shift
x12 dvdd dvdd dvss dvss net1 net2 gf180mcu_as_sc_mcu7t3v3__inv_2
x13 dvdd dvdd dvss dvss s2b s1b s0b net2 gf180mcu_as_sc_mcu7t3v3__nand3_2
x14 dvdd dvdd dvss dvss s0b s[0] gf180mcu_as_sc_mcu7t3v3__inv_2
x15 dvdd dvdd dvss dvss s1b s[1] gf180mcu_as_sc_mcu7t3v3__inv_2
x16 dvdd dvdd dvss dvss s2b s[2] gf180mcu_as_sc_mcu7t3v3__inv_2
x17 dvdd dvdd dvss dvss s0 s0b gf180mcu_as_sc_mcu7t3v3__inv_2
x18 dvdd dvdd dvss dvss s1 s1b gf180mcu_as_sc_mcu7t3v3__inv_2
x19 dvdd dvdd dvss dvss s2 s2b gf180mcu_as_sc_mcu7t3v3__inv_2
x20 vdd v1 v1b vss hv_inv_1
x21 net4 net3 v1 vdd vss level_shift
x22 dvdd dvdd dvss dvss net3 net4 gf180mcu_as_sc_mcu7t3v3__inv_2
x23 dvdd dvdd dvss dvss s2b s1b s0 net4 gf180mcu_as_sc_mcu7t3v3__nand3_2
x24 vdd v2 v2b vss hv_inv_1
x25 net6 net5 v2 vdd vss level_shift
x26 dvdd dvdd dvss dvss net5 net6 gf180mcu_as_sc_mcu7t3v3__inv_2
x27 dvdd dvdd dvss dvss s2b s1 s0b net6 gf180mcu_as_sc_mcu7t3v3__nand3_2
x28 vdd v3 v3b vss hv_inv_1
x29 net8 net7 v3 vdd vss level_shift
x30 dvdd dvdd dvss dvss net7 net8 gf180mcu_as_sc_mcu7t3v3__inv_2
x31 dvdd dvdd dvss dvss s2b s1 s0 net8 gf180mcu_as_sc_mcu7t3v3__nand3_2
x32 vdd v4 v4b vss hv_inv_1
x33 net10 net9 v4 vdd vss level_shift
x34 dvdd dvdd dvss dvss net9 net10 gf180mcu_as_sc_mcu7t3v3__inv_2
x35 dvdd dvdd dvss dvss s2 s1b s0b net10 gf180mcu_as_sc_mcu7t3v3__nand3_2
x36 vdd v5 v5b vss hv_inv_1
x37 net12 net11 v5 vdd vss level_shift
x38 dvdd dvdd dvss dvss net11 net12 gf180mcu_as_sc_mcu7t3v3__inv_2
x39 dvdd dvdd dvss dvss s2 s1b s0 net12 gf180mcu_as_sc_mcu7t3v3__nand3_2
x40 vdd v6 v6b vss hv_inv_1
x41 net14 net13 v6 vdd vss level_shift
x42 dvdd dvdd dvss dvss net13 net14 gf180mcu_as_sc_mcu7t3v3__inv_2
x43 dvdd dvdd dvss dvss s2 s1 s0b net14 gf180mcu_as_sc_mcu7t3v3__nand3_2
x44 vdd v7 v7b vss hv_inv_1
x45 net16 net15 v7 vdd vss level_shift
x46 dvdd dvdd dvss dvss net15 net16 gf180mcu_as_sc_mcu7t3v3__inv_2
x47 dvdd dvdd dvss dvss s2 s1 s0 net16 gf180mcu_as_sc_mcu7t3v3__nand3_2
x1 net18 ena vgen_ena_h vdd vss level_shift
x51 dvdd dvdd dvss dvss net18 ena gf180mcu_as_sc_mcu7t3v3__inv_2
x48 vdd net22 vbg net17 ibias1u_1 vss vgen_ena_h n_amp_large
x49 net19 ena1 vgen_ena1_h vdd vss level_shift
x53 dvdd dvdd dvss dvss net19 ena1 gf180mcu_as_sc_mcu7t3v3__inv_2
x54 net20 ena2 vgen_ena2_h vdd vss level_shift
x55 dvdd dvdd dvss dvss net20 ena2 gf180mcu_as_sc_mcu7t3v3__inv_2
x56 high_h vdd net17 vref3 vss low_h xgate
x57 low_h vdd net17 vref2 vss high_h xgate
x58 net21 high high_h vdd vss level_shift
x59 dvdd dvdd dvss dvss net21 high gf180mcu_as_sc_mcu7t3v3__inv_2
x60 vdd high_h low_h vss hv_inv_1
x67 dvdd dvdd dvss dvss s[0] gf180mcu_as_sc_mcu7t3v3__diode_2
x68 dvdd dvdd dvss dvss gf180mcu_as_sc_mcu7t3v3__fillcap_4
x61 dvdd dvdd dvss dvss s[1] gf180mcu_as_sc_mcu7t3v3__diode_2
x62 dvdd dvdd dvss dvss s[2] gf180mcu_as_sc_mcu7t3v3__diode_2
x63 dvdd dvdd dvss dvss high gf180mcu_as_sc_mcu7t3v3__diode_2
x64 dvdd dvdd dvss dvss ena gf180mcu_as_sc_mcu7t3v3__diode_2
x65 dvdd dvdd dvss dvss ena1 gf180mcu_as_sc_mcu7t3v3__diode_2
x66 dvdd dvdd dvss dvss ena2 gf180mcu_as_sc_mcu7t3v3__diode_2
XC1 vdd net22 cap_mim_2f0_m4m5_noshield c_width=30e-6 c_length=30e-6 m=1
XR11 vref6 vref7 vss ppolyf_u_1k r_width=1e-6 r_length=5e-6 m=1
XR1 vref5 vref6 vss ppolyf_u_1k r_width=1e-6 r_length=5e-6 m=1
XR2 vref4 vref5 vss ppolyf_u_1k r_width=1e-6 r_length=5e-6 m=1
XR3 vref3 vref4 vss ppolyf_u_1k r_width=1e-6 r_length=5e-6 m=1
XR4 vref2 vref3 vss ppolyf_u_1k r_width=1e-6 r_length=5e-6 m=1
XR5 vref1 vref2 vss ppolyf_u_1k r_width=1e-6 r_length=5e-6 m=1
XR6 vref0 vref1 vss ppolyf_u_1k r_width=1e-6 r_length=5e-6 m=1
XR7 vss vref0 vss ppolyf_u_1k r_width=1e-6 r_length=5e-6 m=1
XR8 vss vss vss ppolyf_u_1k r_width=1e-6 r_length=5e-6 m=1
XR9 vss vss vss ppolyf_u_1k r_width=1e-6 r_length=5e-6 m=1
XM2 vref7 net22 vdd vdd pfet_05v0 L=0.50u W=2.0u nf=1 ad='int((nf+1)/2) * W/nf * 0.18u' as='int((nf+2)/2) * W/nf * 0.18u' pd='2*int((nf+1)/2) * (W/nf + 0.18u)'
+ ps='2*int((nf+2)/2) * (W/nf + 0.18u)' nrd='0.18u / W' nrs='0.18u / W' sa=0 sb=0 sd=0 m=1
x50 vdd vout_buf vout_unbuf vout_buf vss ibias1u_2 vgen_ena1_h se_folded_cascode_p_5v
.ends

* expanding   symbol:  xgate.sym # of pins=6
** sym_path: /home/tim/gits/gf180mcu_ocd_chipalooza/dependencies/gf180mcu_ocd_ip__biasgen/xschem/xgate.sym
** sch_path: /home/tim/gits/gf180mcu_ocd_chipalooza/dependencies/gf180mcu_ocd_ip__biasgen/xschem/xgate.sch
.subckt xgate ena_b vdd in out vss ena
*.PININFO out:B in:B vdd:B vss:B ena_b:I ena:I
XM3 in ena out vss nfet_05v0 L=0.60u W=2.0u nf=1 ad='int((nf+1)/2) * W/nf * 0.18u' as='int((nf+2)/2) * W/nf * 0.18u' pd='2*int((nf+1)/2) * (W/nf + 0.18u)'
+ ps='2*int((nf+2)/2) * (W/nf + 0.18u)' nrd='0.18u / W' nrs='0.18u / W' sa=0 sb=0 sd=0 m=1
XM4 in ena_b out vdd pfet_05v0 L=0.50u W=2.0u nf=1 ad='int((nf+1)/2) * W/nf * 0.18u' as='int((nf+2)/2) * W/nf * 0.18u' pd='2*int((nf+1)/2) * (W/nf + 0.18u)'
+ ps='2*int((nf+2)/2) * (W/nf + 0.18u)' nrd='0.18u / W' nrs='0.18u / W' sa=0 sb=0 sd=0 m=1
.ends

* expanding   symbol:  hv_inv_1.sym # of pins=4
** sym_path: /home/tim/gits/gf180mcu_ocd_chipalooza/dependencies/gf180mcu_ocd_ip__biasgen/xschem/hv_inv_1.sym
** sch_path: /home/tim/gits/gf180mcu_ocd_chipalooza/dependencies/gf180mcu_ocd_ip__biasgen/xschem/hv_inv_1.sch
.subckt hv_inv_1 vdd A X vss
*.PININFO A:I vdd:B vss:B X:O
XM3 X A vdd vdd pfet_05v0 L=0.50u W=2.00u nf=1 ad='int((nf+1)/2) * W/nf * 0.18u' as='int((nf+2)/2) * W/nf * 0.18u' pd='2*int((nf+1)/2) * (W/nf + 0.18u)'
+ ps='2*int((nf+2)/2) * (W/nf + 0.18u)' nrd='0.18u / W' nrs='0.18u / W' sa=0 sb=0 sd=0 m=1
XM4 X A vss vss nfet_05v0 L=0.60u W=1.00u nf=1 ad='int((nf+1)/2) * W/nf * 0.18u' as='int((nf+2)/2) * W/nf * 0.18u' pd='2*int((nf+1)/2) * (W/nf + 0.18u)'
+ ps='2*int((nf+2)/2) * (W/nf + 0.18u)' nrd='0.18u / W' nrs='0.18u / W' sa=0 sb=0 sd=0 m=1
.ends

* expanding   symbol:  level_shift.sym # of pins=3
** sym_path: /home/tim/gits/gf180mcu_ocd_chipalooza/dependencies/gf180mcu_ocd_ip__biasgen/xschem/level_shift.sym
** sch_path: /home/tim/gits/gf180mcu_ocd_chipalooza/dependencies/gf180mcu_ocd_ip__biasgen/xschem/level_shift.sch
.subckt level_shift in_n in_p out vdd vss
*.PININFO in_n:I in_p:I out:O
XM9 net1 S1_N vdd vdd pfet_03v3 L=0.5u W=1u nf=1 ad='int((nf+1)/2) * W/nf * 0.18u' as='int((nf+2)/2) * W/nf * 0.18u' pd='2*int((nf+1)/2) * (W/nf + 0.18u)'
+ ps='2*int((nf+2)/2) * (W/nf + 0.18u)' nrd='0.18u / W' nrs='0.18u / W' sa=0 sb=0 sd=0 m=2
XM2 S1_N net1 vdd vdd pfet_03v3 L=0.5u W=1u nf=1 ad='int((nf+1)/2) * W/nf * 0.18u' as='int((nf+2)/2) * W/nf * 0.18u' pd='2*int((nf+1)/2) * (W/nf + 0.18u)'
+ ps='2*int((nf+2)/2) * (W/nf + 0.18u)' nrd='0.18u / W' nrs='0.18u / W' sa=0 sb=0 sd=0 m=2
XM4 S2_N S1_N vdd vdd pfet_03v3 L=0.5u W=2u nf=1 ad='int((nf+1)/2) * W/nf * 0.18u' as='int((nf+2)/2) * W/nf * 0.18u' pd='2*int((nf+1)/2) * (W/nf + 0.18u)'
+ ps='2*int((nf+2)/2) * (W/nf + 0.18u)' nrd='0.18u / W' nrs='0.18u / W' sa=0 sb=0 sd=0 m=2
XM5 out S2_N vdd vdd pfet_03v3 L=0.5u W=2u nf=1 ad='int((nf+1)/2) * W/nf * 0.18u' as='int((nf+2)/2) * W/nf * 0.18u' pd='2*int((nf+1)/2) * (W/nf + 0.18u)'
+ ps='2*int((nf+2)/2) * (W/nf + 0.18u)' nrd='0.18u / W' nrs='0.18u / W' sa=0 sb=0 sd=0 m=2
XM7 net1 in_p vss vss nfet_03v3 L=0.5u W=4u nf=1 ad='int((nf+1)/2) * W/nf * 0.18u' as='int((nf+2)/2) * W/nf * 0.18u' pd='2*int((nf+1)/2) * (W/nf + 0.18u)'
+ ps='2*int((nf+2)/2) * (W/nf + 0.18u)' nrd='0.18u / W' nrs='0.18u / W' sa=0 sb=0 sd=0 m=2
XM1 S1_N in_n vss vss nfet_03v3 L=0.5u W=4u nf=1 ad='int((nf+1)/2) * W/nf * 0.18u' as='int((nf+2)/2) * W/nf * 0.18u' pd='2*int((nf+1)/2) * (W/nf + 0.18u)'
+ ps='2*int((nf+2)/2) * (W/nf + 0.18u)' nrd='0.18u / W' nrs='0.18u / W' sa=0 sb=0 sd=0 m=2
XM3 S2_N S1_N vss vss nfet_03v3 L=0.5u W=1u nf=1 ad='int((nf+1)/2) * W/nf * 0.18u' as='int((nf+2)/2) * W/nf * 0.18u' pd='2*int((nf+1)/2) * (W/nf + 0.18u)'
+ ps='2*int((nf+2)/2) * (W/nf + 0.18u)' nrd='0.18u / W' nrs='0.18u / W' sa=0 sb=0 sd=0 m=2
XM6 out S2_N vss vss nfet_03v3 L=0.5u W=1u nf=1 ad='int((nf+1)/2) * W/nf * 0.18u' as='int((nf+2)/2) * W/nf * 0.18u' pd='2*int((nf+1)/2) * (W/nf + 0.18u)'
+ ps='2*int((nf+2)/2) * (W/nf + 0.18u)' nrd='0.18u / W' nrs='0.18u / W' sa=0 sb=0 sd=0 m=2
.ends

* expanding   symbol:  n_amp_large.sym # of pins=7
** sym_path: /home/tim/gits/gf180mcu_ocd_chipalooza/dependencies/gf180mcu_ocd_ip__biasgen/xschem/n_amp_large.sym
** sch_path: /home/tim/gits/gf180mcu_ocd_chipalooza/dependencies/gf180mcu_ocd_ip__biasgen/xschem/n_amp_large.sch
.subckt n_amp_large avdd out inn inp ibias avss ena
*.PININFO inp:I inn:I out:O avdd:B avss:B ena:I ibias:B
XM9 out outn avdd avdd pfet_05v0 L=0.50u W=10.0u nf=10 ad='int((nf+1)/2) * W/nf * 0.18u' as='int((nf+2)/2) * W/nf * 0.18u' pd='2*int((nf+1)/2) * (W/nf + 0.18u)'
+ ps='2*int((nf+2)/2) * (W/nf + 0.18u)' nrd='0.18u / W' nrs='0.18u / W' sa=0 sb=0 sd=0 m=1
XM10 vcom net1 avss avss nfet_05v0 L=0.60u W=20.0u nf=20 ad='int((nf+1)/2) * W/nf * 0.18u' as='int((nf+2)/2) * W/nf * 0.18u' pd='2*int((nf+1)/2) * (W/nf + 0.18u)'
+ ps='2*int((nf+2)/2) * (W/nf + 0.18u)' nrd='0.18u / W' nrs='0.18u / W' sa=0 sb=0 sd=0 m=1
XM1 ibias ena net1 avss nfet_05v0 L=0.60u W=20.0u nf=20 ad='int((nf+1)/2) * W/nf * 0.18u' as='int((nf+2)/2) * W/nf * 0.18u' pd='2*int((nf+1)/2) * (W/nf + 0.18u)'
+ ps='2*int((nf+2)/2) * (W/nf + 0.18u)' nrd='0.18u / W' nrs='0.18u / W' sa=0 sb=0 sd=0 m=1
XM6 net1 net1 avss avss nfet_05v0 L=0.60u W=20.0u nf=20 ad='int((nf+1)/2) * W/nf * 0.18u' as='int((nf+2)/2) * W/nf * 0.18u' pd='2*int((nf+1)/2) * (W/nf + 0.18u)'
+ ps='2*int((nf+2)/2) * (W/nf + 0.18u)' nrd='0.18u / W' nrs='0.18u / W' sa=0 sb=0 sd=0 m=1
XM4 outn inp vcom avss nfet_05v0 L=0.60u W=20.0u nf=20 ad='int((nf+1)/2) * W/nf * 0.18u' as='int((nf+2)/2) * W/nf * 0.18u' pd='2*int((nf+1)/2) * (W/nf + 0.18u)'
+ ps='2*int((nf+2)/2) * (W/nf + 0.18u)' nrd='0.18u / W' nrs='0.18u / W' sa=0 sb=0 sd=0 m=1
XM5 out inn vcom avss nfet_05v0 L=0.60u W=20.0u nf=20 ad='int((nf+1)/2) * W/nf * 0.18u' as='int((nf+2)/2) * W/nf * 0.18u' pd='2*int((nf+1)/2) * (W/nf + 0.18u)'
+ ps='2*int((nf+2)/2) * (W/nf + 0.18u)' nrd='0.18u / W' nrs='0.18u / W' sa=0 sb=0 sd=0 m=1
XM2 outn outn avdd avdd pfet_05v0 L=0.50u W=10.0u nf=10 ad='int((nf+1)/2) * W/nf * 0.18u' as='int((nf+2)/2) * W/nf * 0.18u' pd='2*int((nf+1)/2) * (W/nf + 0.18u)'
+ ps='2*int((nf+2)/2) * (W/nf + 0.18u)' nrd='0.18u / W' nrs='0.18u / W' sa=0 sb=0 sd=0 m=1
XM3 avdd avdd avdd avdd pfet_05v0 L=0.50u W=2.0u nf=2 ad='int((nf+1)/2) * W/nf * 0.18u' as='int((nf+2)/2) * W/nf * 0.18u' pd='2*int((nf+1)/2) * (W/nf + 0.18u)'
+ ps='2*int((nf+2)/2) * (W/nf + 0.18u)' nrd='0.18u / W' nrs='0.18u / W' sa=0 sb=0 sd=0 m=1
.ends

* expanding   symbol:  se_folded_cascode_p_5v.sym # of pins=7
** sym_path: /home/tim/gits/gf180mcu_ocd_chipalooza/dependencies/gf180mcu_ocd_ip__biasgen/xschem/se_folded_cascode_p_5v.sym
** sch_path: /home/tim/gits/gf180mcu_ocd_chipalooza/dependencies/gf180mcu_ocd_ip__biasgen/xschem/se_folded_cascode_p_5v.sch
.subckt se_folded_cascode_p_5v vdd out inp inn vss bias ena
*.PININFO inn:I inp:I out:O bias:B vdd:B vss:B ena:I
XM16 vbn2 vbn2 vbn1 vss nfet_05v0 L=4.0u W=1.0u nf=1 ad='int((nf+1)/2) * W/nf * 0.18u' as='int((nf+2)/2) * W/nf * 0.18u' pd='2*int((nf+1)/2) * (W/nf + 0.18u)'
+ ps='2*int((nf+2)/2) * (W/nf + 0.18u)' nrd='0.18u / W' nrs='0.18u / W' sa=0 sb=0 sd=0 m=4
XM22 vbp1 vbp1 vdd vdd pfet_05v0 L=1.0u W=1.0u nf=1 ad='int((nf+1)/2) * W/nf * 0.18u' as='int((nf+2)/2) * W/nf * 0.18u' pd='2*int((nf+1)/2) * (W/nf + 0.18u)'
+ ps='2*int((nf+2)/2) * (W/nf + 0.18u)' nrd='0.18u / W' nrs='0.18u / W' sa=0 sb=0 sd=0 m=4
XM23 vbn2 vbp1 vdd vdd pfet_05v0 L=1.0u W=1.0u nf=1 ad='int((nf+1)/2) * W/nf * 0.18u' as='int((nf+2)/2) * W/nf * 0.18u' pd='2*int((nf+1)/2) * (W/nf + 0.18u)'
+ ps='2*int((nf+2)/2) * (W/nf + 0.18u)' nrd='0.18u / W' nrs='0.18u / W' sa=0 sb=0 sd=0 m=4
XM24 bias ena vdd vdd pfet_05v0 L=0.5u W=1.0u nf=1 ad='int((nf+1)/2) * W/nf * 0.18u' as='int((nf+2)/2) * W/nf * 0.18u' pd='2*int((nf+1)/2) * (W/nf + 0.18u)'
+ ps='2*int((nf+2)/2) * (W/nf + 0.18u)' nrd='0.18u / W' nrs='0.18u / W' sa=0 sb=0 sd=0 m=1
XM25 diff vbp1 vdd vdd pfet_05v0 L=1.0u W=1.0u nf=1 ad='int((nf+1)/2) * W/nf * 0.18u' as='int((nf+2)/2) * W/nf * 0.18u' pd='2*int((nf+1)/2) * (W/nf + 0.18u)'
+ ps='2*int((nf+2)/2) * (W/nf + 0.18u)' nrd='0.18u / W' nrs='0.18u / W' sa=0 sb=0 sd=0 m=16
XM26 out1n inp diff vdd pfet_05v0 L=1.0u W=4.0u nf=1 ad='int((nf+1)/2) * W/nf * 0.18u' as='int((nf+2)/2) * W/nf * 0.18u' pd='2*int((nf+1)/2) * (W/nf + 0.18u)'
+ ps='2*int((nf+2)/2) * (W/nf + 0.18u)' nrd='0.18u / W' nrs='0.18u / W' sa=0 sb=0 sd=0 m=8
XM27 out1p inn diff vdd pfet_05v0 L=1.0u W=4.0u nf=1 ad='int((nf+1)/2) * W/nf * 0.18u' as='int((nf+2)/2) * W/nf * 0.18u' pd='2*int((nf+1)/2) * (W/nf + 0.18u)'
+ ps='2*int((nf+2)/2) * (W/nf + 0.18u)' nrd='0.18u / W' nrs='0.18u / W' sa=0 sb=0 sd=0 m=8
XM28 nd10 mirr vdd vdd pfet_05v0 L=4.0u W=2.0u nf=1 ad='int((nf+1)/2) * W/nf * 0.18u' as='int((nf+2)/2) * W/nf * 0.18u' pd='2*int((nf+1)/2) * (W/nf + 0.18u)'
+ ps='2*int((nf+2)/2) * (W/nf + 0.18u)' nrd='0.18u / W' nrs='0.18u / W' sa=0 sb=0 sd=0 m=8
XM29 nd11 mirr vdd vdd pfet_05v0 L=4.0u W=2.0u nf=1 ad='int((nf+1)/2) * W/nf * 0.18u' as='int((nf+2)/2) * W/nf * 0.18u' pd='2*int((nf+1)/2) * (W/nf + 0.18u)'
+ ps='2*int((nf+2)/2) * (W/nf + 0.18u)' nrd='0.18u / W' nrs='0.18u / W' sa=0 sb=0 sd=0 m=8
XM30 out bias nd11 vdd pfet_05v0 L=4.0u W=2.0u nf=1 ad='int((nf+1)/2) * W/nf * 0.18u' as='int((nf+2)/2) * W/nf * 0.18u' pd='2*int((nf+1)/2) * (W/nf + 0.18u)'
+ ps='2*int((nf+2)/2) * (W/nf + 0.18u)' nrd='0.18u / W' nrs='0.18u / W' sa=0 sb=0 sd=0 m=8
XM31 mirr bias nd10 vdd pfet_05v0 L=4.0u W=2.0u nf=1 ad='int((nf+1)/2) * W/nf * 0.18u' as='int((nf+2)/2) * W/nf * 0.18u' pd='2*int((nf+1)/2) * (W/nf + 0.18u)'
+ ps='2*int((nf+2)/2) * (W/nf + 0.18u)' nrd='0.18u / W' nrs='0.18u / W' sa=0 sb=0 sd=0 m=8
XM1 bias bias vbp1 vdd pfet_05v0 L=4.0u W=2.0u nf=1 ad='int((nf+1)/2) * W/nf * 0.18u' as='int((nf+2)/2) * W/nf * 0.18u' pd='2*int((nf+1)/2) * (W/nf + 0.18u)'
+ ps='2*int((nf+2)/2) * (W/nf + 0.18u)' nrd='0.18u / W' nrs='0.18u / W' sa=0 sb=0 sd=0 m=4
XM2 vbn1 vbn1 vss vss nfet_05v0 L=1.0u W=1.0u nf=1 ad='int((nf+1)/2) * W/nf * 0.18u' as='int((nf+2)/2) * W/nf * 0.18u' pd='2*int((nf+1)/2) * (W/nf + 0.18u)'
+ ps='2*int((nf+2)/2) * (W/nf + 0.18u)' nrd='0.18u / W' nrs='0.18u / W' sa=0 sb=0 sd=0 m=4
XM3 out1p vbn1 vss vss nfet_05v0 L=1.0u W=1.0u nf=1 ad='int((nf+1)/2) * W/nf * 0.18u' as='int((nf+2)/2) * W/nf * 0.18u' pd='2*int((nf+1)/2) * (W/nf + 0.18u)'
+ ps='2*int((nf+2)/2) * (W/nf + 0.18u)' nrd='0.18u / W' nrs='0.18u / W' sa=0 sb=0 sd=0 m=16
XM5 out1n vbn1 vss vss nfet_05v0 L=1.0u W=1.0u nf=1 ad='int((nf+1)/2) * W/nf * 0.18u' as='int((nf+2)/2) * W/nf * 0.18u' pd='2*int((nf+1)/2) * (W/nf + 0.18u)'
+ ps='2*int((nf+2)/2) * (W/nf + 0.18u)' nrd='0.18u / W' nrs='0.18u / W' sa=0 sb=0 sd=0 m=16
XM6 mirr vbn2 out1n vss nfet_05v0 L=4.0u W=1.0u nf=1 ad='int((nf+1)/2) * W/nf * 0.18u' as='int((nf+2)/2) * W/nf * 0.18u' pd='2*int((nf+1)/2) * (W/nf + 0.18u)'
+ ps='2*int((nf+2)/2) * (W/nf + 0.18u)' nrd='0.18u / W' nrs='0.18u / W' sa=0 sb=0 sd=0 m=8
XM4 out vbn2 out1p vss nfet_05v0 L=4.0u W=1.0u nf=1 ad='int((nf+1)/2) * W/nf * 0.18u' as='int((nf+2)/2) * W/nf * 0.18u' pd='2*int((nf+1)/2) * (W/nf + 0.18u)'
+ ps='2*int((nf+2)/2) * (W/nf + 0.18u)' nrd='0.18u / W' nrs='0.18u / W' sa=0 sb=0 sd=0 m=8
XM7 vss vss vss vss nfet_05v0 L=1.0u W=1.0u nf=1 ad='int((nf+1)/2) * W/nf * 0.18u' as='int((nf+2)/2) * W/nf * 0.18u' pd='2*int((nf+1)/2) * (W/nf + 0.18u)'
+ ps='2*int((nf+2)/2) * (W/nf + 0.18u)' nrd='0.18u / W' nrs='0.18u / W' sa=0 sb=0 sd=0 m=16
XM8 vdd vdd vdd vdd pfet_05v0 L=1.0u W=4.0u nf=1 ad='int((nf+1)/2) * W/nf * 0.18u' as='int((nf+2)/2) * W/nf * 0.18u' pd='2*int((nf+1)/2) * (W/nf + 0.18u)'
+ ps='2*int((nf+2)/2) * (W/nf + 0.18u)' nrd='0.18u / W' nrs='0.18u / W' sa=0 sb=0 sd=0 m=8
XM9 vdd vdd vdd vdd pfet_05v0 L=1.0u W=1.0u nf=1 ad='int((nf+1)/2) * W/nf * 0.18u' as='int((nf+2)/2) * W/nf * 0.18u' pd='2*int((nf+1)/2) * (W/nf + 0.18u)'
+ ps='2*int((nf+2)/2) * (W/nf + 0.18u)' nrd='0.18u / W' nrs='0.18u / W' sa=0 sb=0 sd=0 m=8
.ends
