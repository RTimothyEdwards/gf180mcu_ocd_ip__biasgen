** sch_path: /home/tim/gits/gf180mcu_ocd_chipalooza/dependencies/gf180mcu_ocd_ip__biasgen/xschem/gf180mcu_ocd_ip__bandgap.sch
.subckt gf180mcu_ocd_ip__bandgap vdd vbg vss ibias1_250n trim[15] trim[14] trim[13] trim[12] trim[11] trim[10] trim[9] trim[8]
+ trim[7] trim[6] trim[5] trim[4] trim[3] trim[2] trim[1] trim[0] dvss dvdd ena ibias2_1u
*.PININFO trim[15:0]:I ena:I vbg:O ibias2_1u:B ibias1_250n:B vdd:B dvdd:B dvss:B vss:B
x1 vdd vbg_unbuf vss ibias1_250n trim[15] trim[14] trim[13] trim[12] trim[11] trim[10] trim[9] trim[8] trim[7] trim[6] trim[5]
+ trim[4] trim[3] trim[2] trim[1] trim[0] dvss dvdd ena ena_h bandgap_unbuffered
x2 vdd vbg vbg_unbuf vbg vss ibias2_1u ena_h se_folded_cascode_np_ab
.ends

* expanding   symbol:  bandgap_unbuffered.sym # of pins=9
** sym_path: /home/tim/gits/gf180mcu_ocd_chipalooza/dependencies/gf180mcu_ocd_ip__biasgen/xschem/bandgap_unbuffered.sym
** sch_path: /home/tim/gits/gf180mcu_ocd_chipalooza/dependencies/gf180mcu_ocd_ip__biasgen/xschem/bandgap_unbuffered.sch
.subckt bandgap_unbuffered vdd vbg vss bias trim[15] trim[14] trim[13] trim[12] trim[11] trim[10] trim[9] trim[8] trim[7] trim[6]
+ trim[5] trim[4] trim[3] trim[2] trim[1] trim[0] dvss dvdd ena ena_h
*.PININFO vdd:B vss:B vbg:O bias:B trim[15:0]:I dvss:B dvdd:B ena:I ena_h:O
xres vbg comp vp vn vss net7 vss vss vp vss vss bg_res
xtr net1 net2 net4[15] net4[14] net4[13] net4[12] net4[11] net4[10] net4[9] net4[8] net4[7] net4[6] net4[5] net4[4] net4[3]
+ net4[2] net4[1] net4[0] vss bg_trim
xamp vdd gate vp vn vss bias ena_h se_folded_cascode_p
x1[15] net3[15] trim[15] net4[15] vdd vss level_shift
x1[14] net3[14] trim[14] net4[14] vdd vss level_shift
x1[13] net3[13] trim[13] net4[13] vdd vss level_shift
x1[12] net3[12] trim[12] net4[12] vdd vss level_shift
x1[11] net3[11] trim[11] net4[11] vdd vss level_shift
x1[10] net3[10] trim[10] net4[10] vdd vss level_shift
x1[9] net3[9] trim[9] net4[9] vdd vss level_shift
x1[8] net3[8] trim[8] net4[8] vdd vss level_shift
x1[7] net3[7] trim[7] net4[7] vdd vss level_shift
x1[6] net3[6] trim[6] net4[6] vdd vss level_shift
x1[5] net3[5] trim[5] net4[5] vdd vss level_shift
x1[4] net3[4] trim[4] net4[4] vdd vss level_shift
x1[3] net3[3] trim[3] net4[3] vdd vss level_shift
x1[2] net3[2] trim[2] net4[2] vdd vss level_shift
x1[1] net3[1] trim[1] net4[1] vdd vss level_shift
x1[0] net3[0] trim[0] net4[0] vdd vss level_shift
x3 net5 ena ena_h vdd vss level_shift
x2 dvdd dvdd dvss dvss ena gf180mcu_as_sc_mcu7t3v3__diode_2
x5 dvdd dvdd dvss dvss net5 ena gf180mcu_as_sc_mcu7t3v3__inv_2
x6[4] dvdd dvdd dvss dvss gf180mcu_as_sc_mcu7t3v3__fillcap_4
x6[3] dvdd dvdd dvss dvss gf180mcu_as_sc_mcu7t3v3__fillcap_4
x6[2] dvdd dvdd dvss dvss gf180mcu_as_sc_mcu7t3v3__fillcap_4
x6[1] dvdd dvdd dvss dvss gf180mcu_as_sc_mcu7t3v3__fillcap_4
x6[0] dvdd dvdd dvss dvss gf180mcu_as_sc_mcu7t3v3__fillcap_4
x2[15] dvdd dvdd dvss dvss net3[15] trim[15] gf180mcu_as_sc_mcu7t3v3__inv_2
x2[14] dvdd dvdd dvss dvss net3[14] trim[14] gf180mcu_as_sc_mcu7t3v3__inv_2
x2[13] dvdd dvdd dvss dvss net3[13] trim[13] gf180mcu_as_sc_mcu7t3v3__inv_2
x2[12] dvdd dvdd dvss dvss net3[12] trim[12] gf180mcu_as_sc_mcu7t3v3__inv_2
x2[11] dvdd dvdd dvss dvss net3[11] trim[11] gf180mcu_as_sc_mcu7t3v3__inv_2
x2[10] dvdd dvdd dvss dvss net3[10] trim[10] gf180mcu_as_sc_mcu7t3v3__inv_2
x2[9] dvdd dvdd dvss dvss net3[9] trim[9] gf180mcu_as_sc_mcu7t3v3__inv_2
x2[8] dvdd dvdd dvss dvss net3[8] trim[8] gf180mcu_as_sc_mcu7t3v3__inv_2
x2[7] dvdd dvdd dvss dvss net3[7] trim[7] gf180mcu_as_sc_mcu7t3v3__inv_2
x2[6] dvdd dvdd dvss dvss net3[6] trim[6] gf180mcu_as_sc_mcu7t3v3__inv_2
x2[5] dvdd dvdd dvss dvss net3[5] trim[5] gf180mcu_as_sc_mcu7t3v3__inv_2
x2[4] dvdd dvdd dvss dvss net3[4] trim[4] gf180mcu_as_sc_mcu7t3v3__inv_2
x2[3] dvdd dvdd dvss dvss net3[3] trim[3] gf180mcu_as_sc_mcu7t3v3__inv_2
x2[2] dvdd dvdd dvss dvss net3[2] trim[2] gf180mcu_as_sc_mcu7t3v3__inv_2
x2[1] dvdd dvdd dvss dvss net3[1] trim[1] gf180mcu_as_sc_mcu7t3v3__inv_2
x2[0] dvdd dvdd dvss dvss net3[0] trim[0] gf180mcu_as_sc_mcu7t3v3__inv_2
x3[15] dvdd dvdd dvss dvss trim[15] gf180mcu_as_sc_mcu7t3v3__diode_2
x3[14] dvdd dvdd dvss dvss trim[14] gf180mcu_as_sc_mcu7t3v3__diode_2
x3[13] dvdd dvdd dvss dvss trim[13] gf180mcu_as_sc_mcu7t3v3__diode_2
x3[12] dvdd dvdd dvss dvss trim[12] gf180mcu_as_sc_mcu7t3v3__diode_2
x3[11] dvdd dvdd dvss dvss trim[11] gf180mcu_as_sc_mcu7t3v3__diode_2
x3[10] dvdd dvdd dvss dvss trim[10] gf180mcu_as_sc_mcu7t3v3__diode_2
x3[9] dvdd dvdd dvss dvss trim[9] gf180mcu_as_sc_mcu7t3v3__diode_2
x3[8] dvdd dvdd dvss dvss trim[8] gf180mcu_as_sc_mcu7t3v3__diode_2
x3[7] dvdd dvdd dvss dvss trim[7] gf180mcu_as_sc_mcu7t3v3__diode_2
x3[6] dvdd dvdd dvss dvss trim[6] gf180mcu_as_sc_mcu7t3v3__diode_2
x3[5] dvdd dvdd dvss dvss trim[5] gf180mcu_as_sc_mcu7t3v3__diode_2
x3[4] dvdd dvdd dvss dvss trim[4] gf180mcu_as_sc_mcu7t3v3__diode_2
x3[3] dvdd dvdd dvss dvss trim[3] gf180mcu_as_sc_mcu7t3v3__diode_2
x3[2] dvdd dvdd dvss dvss trim[2] gf180mcu_as_sc_mcu7t3v3__diode_2
x3[1] dvdd dvdd dvss dvss trim[1] gf180mcu_as_sc_mcu7t3v3__diode_2
x3[0] dvdd dvdd dvss dvss trim[0] gf180mcu_as_sc_mcu7t3v3__diode_2
x4[1] dvss dvdd gf180mcu_as_sc_mcu7t3v3__tap_2
x4[0] dvss dvdd gf180mcu_as_sc_mcu7t3v3__tap_2
XQ3 vss vss net2 pnp_05p00x05p00 m=8 par=8
XQ1 vss vss net6 pnp_05p00x05p00 m=1 par=1
XC1 vs2 vss cap_mim_2f0_m4m5_noshield c_width=22e-6 c_length=22e-6 m=1
XC2 vdd vss cap_mim_2f0_m4m5_noshield c_width=22e-6 c_length=22e-6 m=1
XC3 gate vss cap_mim_2f0_m4m5_noshield c_width=30e-6 c_length=30e-6 m=1
XM8 comp gate vdd vdd pfet_03v3 L=0.5u W=4u nf=1 ad='int((nf+1)/2) * W/nf * 0.18u' as='int((nf+2)/2) * W/nf * 0.18u' pd='2*int((nf+1)/2) * (W/nf + 0.18u)'
+ ps='2*int((nf+2)/2) * (W/nf + 0.18u)' nrd='0.18u / W' nrs='0.18u / W' sa=0 sb=0 sd=0 m=2 par=2
XM1 vbg gate vdd vdd pfet_03v3 L=0.5u W=4u nf=1 ad='int((nf+1)/2) * W/nf * 0.18u' as='int((nf+2)/2) * W/nf * 0.18u' pd='2*int((nf+1)/2) * (W/nf + 0.18u)'
+ ps='2*int((nf+2)/2) * (W/nf + 0.18u)' nrd='0.18u / W' nrs='0.18u / W' sa=0 sb=0 sd=0 m=2 par=2
XM2 vs1 vbg vss vss nfet_03v3 L=1u W=1u nf=1 ad='int((nf+1)/2) * W/nf * 0.18u' as='int((nf+2)/2) * W/nf * 0.18u' pd='2*int((nf+1)/2) * (W/nf + 0.18u)'
+ ps='2*int((nf+2)/2) * (W/nf + 0.18u)' nrd='0.18u / W' nrs='0.18u / W' sa=0 sb=0 sd=0 m=1 par=1
XM9 vs1 vs2 vdd vdd pfet_03v3 L=1u W=1u nf=1 ad='int((nf+1)/2) * W/nf * 0.18u' as='int((nf+2)/2) * W/nf * 0.18u' pd='2*int((nf+1)/2) * (W/nf + 0.18u)'
+ ps='2*int((nf+2)/2) * (W/nf + 0.18u)' nrd='0.18u / W' nrs='0.18u / W' sa=0 sb=0 sd=0 m=1 par=1
XM5 vs2 vs2 vdd vdd pfet_03v3 L=1u W=1u nf=1 ad='int((nf+1)/2) * W/nf * 0.18u' as='int((nf+2)/2) * W/nf * 0.18u' pd='2*int((nf+1)/2) * (W/nf + 0.18u)'
+ ps='2*int((nf+2)/2) * (W/nf + 0.18u)' nrd='0.18u / W' nrs='0.18u / W' sa=0 sb=0 sd=0 m=1 par=1
XM6 vss vdd vs2 vs2 pfet_03v3 L=1u W=1u nf=1 ad='int((nf+1)/2) * W/nf * 0.18u' as='int((nf+2)/2) * W/nf * 0.18u' pd='2*int((nf+1)/2) * (W/nf + 0.18u)'
+ ps='2*int((nf+2)/2) * (W/nf + 0.18u)' nrd='0.18u / W' nrs='0.18u / W' sa=0 sb=0 sd=0 m=1 par=1
XM3 gate vs1 vss vss nfet_03v3 L=1u W=1u nf=1 ad='int((nf+1)/2) * W/nf * 0.18u' as='int((nf+2)/2) * W/nf * 0.18u' pd='2*int((nf+1)/2) * (W/nf + 0.18u)'
+ ps='2*int((nf+2)/2) * (W/nf + 0.18u)' nrd='0.18u / W' nrs='0.18u / W' sa=0 sb=0 sd=0 m=1 par=1
Vmeas vn net6 0
.save i(vmeas)
Vmeas1 net7 net1 0
.save i(vmeas1)
.ends

* expanding   symbol:  se_folded_cascode_np_ab.sym # of pins=7
** sym_path: /home/tim/gits/gf180mcu_ocd_chipalooza/dependencies/gf180mcu_ocd_ip__biasgen/xschem/se_folded_cascode_np_ab.sym
** sch_path: /home/tim/gits/gf180mcu_ocd_chipalooza/dependencies/gf180mcu_ocd_ip__biasgen/xschem/se_folded_cascode_np_ab.sch
.subckt se_folded_cascode_np_ab vdd out inp inn vss bias ena
*.PININFO vdd:B bias:B inp:I inn:I vss:B out:O ena:I
XC2 out outs1 cap_mim_2f0_m4m5_noshield c_width=26.5e-6 c_length=26.5e-6 m=1
XM1 vbn2 vbp1 vdd vdd pfet_03v3 L=1.0u W=1.0u nf=1 ad='int((nf+1)/2) * W/nf * 0.18u' as='int((nf+2)/2) * W/nf * 0.18u' pd='2*int((nf+1)/2) * (W/nf + 0.18u)'
+ ps='2*int((nf+2)/2) * (W/nf + 0.18u)' nrd='0.18u / W' nrs='0.18u / W' sa=0 sb=0 sd=0 m=4 par=4
XM3 bias bias vbp1 vdd pfet_03v3 L=0.5u W=1.0u nf=1 ad='int((nf+1)/2) * W/nf * 0.18u' as='int((nf+2)/2) * W/nf * 0.18u' pd='2*int((nf+1)/2) * (W/nf + 0.18u)'
+ ps='2*int((nf+2)/2) * (W/nf + 0.18u)' nrd='0.18u / W' nrs='0.18u / W' sa=0 sb=0 sd=0 m=4 par=4
XM12 diffb vbp1 vdd vdd pfet_03v3 L=1.0u W=1.0u nf=1 ad='int((nf+1)/2) * W/nf * 0.18u' as='int((nf+2)/2) * W/nf * 0.18u' pd='2*int((nf+1)/2) * (W/nf + 0.18u)'
+ ps='2*int((nf+2)/2) * (W/nf + 0.18u)' nrd='0.18u / W' nrs='0.18u / W' sa=0 sb=0 sd=0 m=16 par=16
XM13 outb1n inn diffb vdd pfet_03v3 L=1u W=4u nf=1 ad='int((nf+1)/2) * W/nf * 0.18u' as='int((nf+2)/2) * W/nf * 0.18u' pd='2*int((nf+1)/2) * (W/nf + 0.18u)'
+ ps='2*int((nf+2)/2) * (W/nf + 0.18u)' nrd='0.18u / W' nrs='0.18u / W' sa=0 sb=0 sd=0 m=8 par=8
XM16 outa1n outa1n vdd vdd pfet_03v3 L=1u W=1u nf=1 ad='int((nf+1)/2) * W/nf * 0.18u' as='int((nf+2)/2) * W/nf * 0.18u' pd='2*int((nf+1)/2) * (W/nf + 0.18u)'
+ ps='2*int((nf+2)/2) * (W/nf + 0.18u)' nrd='0.18u / W' nrs='0.18u / W' sa=0 sb=0 sd=0 m=12 par=12
XM17 out outs1 vdd vdd pfet_03v3 L=4u W=4u nf=1 ad='int((nf+1)/2) * W/nf * 0.18u' as='int((nf+2)/2) * W/nf * 0.18u' pd='2*int((nf+1)/2) * (W/nf + 0.18u)'
+ ps='2*int((nf+2)/2) * (W/nf + 0.18u)' nrd='0.18u / W' nrs='0.18u / W' sa=0 sb=0 sd=0 m=4 par=4
XM18 vbp1 vbp1 vdd vdd pfet_03v3 L=1.0u W=1.0u nf=1 ad='int((nf+1)/2) * W/nf * 0.18u' as='int((nf+2)/2) * W/nf * 0.18u' pd='2*int((nf+1)/2) * (W/nf + 0.18u)'
+ ps='2*int((nf+2)/2) * (W/nf + 0.18u)' nrd='0.18u / W' nrs='0.18u / W' sa=0 sb=0 sd=0 m=4 par=4
XM15 outa1p outa1n vdd vdd pfet_03v3 L=1u W=1u nf=1 ad='int((nf+1)/2) * W/nf * 0.18u' as='int((nf+2)/2) * W/nf * 0.18u' pd='2*int((nf+1)/2) * (W/nf + 0.18u)'
+ ps='2*int((nf+2)/2) * (W/nf + 0.18u)' nrd='0.18u / W' nrs='0.18u / W' sa=0 sb=0 sd=0 m=12 par=12
XM4 mirr mirr outa1n vdd pfet_03v3 L=4.0u W=1.0u nf=1 ad='int((nf+1)/2) * W/nf * 0.18u' as='int((nf+2)/2) * W/nf * 0.18u' pd='2*int((nf+1)/2) * (W/nf + 0.18u)'
+ ps='2*int((nf+2)/2) * (W/nf + 0.18u)' nrd='0.18u / W' nrs='0.18u / W' sa=0 sb=0 sd=0 m=16 par=16
XM5 outs1 mirr outa1p vdd pfet_03v3 L=4.0u W=1.0u nf=1 ad='int((nf+1)/2) * W/nf * 0.18u' as='int((nf+2)/2) * W/nf * 0.18u' pd='2*int((nf+1)/2) * (W/nf + 0.18u)'
+ ps='2*int((nf+2)/2) * (W/nf + 0.18u)' nrd='0.18u / W' nrs='0.18u / W' sa=0 sb=0 sd=0 m=16 par=16
XM6 outb1p inp diffb vdd pfet_03v3 L=1u W=4u nf=1 ad='int((nf+1)/2) * W/nf * 0.18u' as='int((nf+2)/2) * W/nf * 0.18u' pd='2*int((nf+1)/2) * (W/nf + 0.18u)'
+ ps='2*int((nf+2)/2) * (W/nf + 0.18u)' nrd='0.18u / W' nrs='0.18u / W' sa=0 sb=0 sd=0 m=8 par=8
XM7 vbn2 vbn2 vbn1 vss nfet_03v3 L=4u W=2u nf=1 ad='int((nf+1)/2) * W/nf * 0.18u' as='int((nf+2)/2) * W/nf * 0.18u' pd='2*int((nf+1)/2) * (W/nf + 0.18u)'
+ ps='2*int((nf+2)/2) * (W/nf + 0.18u)' nrd='0.18u / W' nrs='0.18u / W' sa=0 sb=0 sd=0 m=4 par=4
XM19 vbn1 vbn1 vss vss nfet_03v3 L=1u W=1u nf=1 ad='int((nf+1)/2) * W/nf * 0.18u' as='int((nf+2)/2) * W/nf * 0.18u' pd='2*int((nf+1)/2) * (W/nf + 0.18u)'
+ ps='2*int((nf+2)/2) * (W/nf + 0.18u)' nrd='0.18u / W' nrs='0.18u / W' sa=0 sb=0 sd=0 m=4 par=4
XM20 outa1n inn diffa vss nfet_03v3 L=1u W=2u nf=1 ad='int((nf+1)/2) * W/nf * 0.18u' as='int((nf+2)/2) * W/nf * 0.18u' pd='2*int((nf+1)/2) * (W/nf + 0.18u)'
+ ps='2*int((nf+2)/2) * (W/nf + 0.18u)' nrd='0.18u / W' nrs='0.18u / W' sa=0 sb=0 sd=0 m=8 par=8
XM21 outa1p inp diffa vss nfet_03v3 L=1u W=2u nf=1 ad='int((nf+1)/2) * W/nf * 0.18u' as='int((nf+2)/2) * W/nf * 0.18u' pd='2*int((nf+1)/2) * (W/nf + 0.18u)'
+ ps='2*int((nf+2)/2) * (W/nf + 0.18u)' nrd='0.18u / W' nrs='0.18u / W' sa=0 sb=0 sd=0 m=8 par=8
XM22 diffa vbn1 vss vss nfet_03v3 L=1u W=1u nf=1 ad='int((nf+1)/2) * W/nf * 0.18u' as='int((nf+2)/2) * W/nf * 0.18u' pd='2*int((nf+1)/2) * (W/nf + 0.18u)'
+ ps='2*int((nf+2)/2) * (W/nf + 0.18u)' nrd='0.18u / W' nrs='0.18u / W' sa=0 sb=0 sd=0 m=8 par=8
XM14 outb1n vbn1 vss vss nfet_03v3 L=1u W=1u nf=1 ad='int((nf+1)/2) * W/nf * 0.18u' as='int((nf+2)/2) * W/nf * 0.18u' pd='2*int((nf+1)/2) * (W/nf + 0.18u)'
+ ps='2*int((nf+2)/2) * (W/nf + 0.18u)' nrd='0.18u / W' nrs='0.18u / W' sa=0 sb=0 sd=0 m=24 par=24
XM10 outb1p vbn1 vss vss nfet_03v3 L=1u W=1u nf=1 ad='int((nf+1)/2) * W/nf * 0.18u' as='int((nf+2)/2) * W/nf * 0.18u' pd='2*int((nf+1)/2) * (W/nf + 0.18u)'
+ ps='2*int((nf+2)/2) * (W/nf + 0.18u)' nrd='0.18u / W' nrs='0.18u / W' sa=0 sb=0 sd=0 m=24 par=24
XM8 mirr vbn2 outb1n vss nfet_03v3 L=4u W=2u nf=1 ad='int((nf+1)/2) * W/nf * 0.18u' as='int((nf+2)/2) * W/nf * 0.18u' pd='2*int((nf+1)/2) * (W/nf + 0.18u)'
+ ps='2*int((nf+2)/2) * (W/nf + 0.18u)' nrd='0.18u / W' nrs='0.18u / W' sa=0 sb=0 sd=0 m=16 par=16
XM9 outs1 vbn2 outb1p vss nfet_03v3 L=4u W=2u nf=1 ad='int((nf+1)/2) * W/nf * 0.18u' as='int((nf+2)/2) * W/nf * 0.18u' pd='2*int((nf+1)/2) * (W/nf + 0.18u)'
+ ps='2*int((nf+2)/2) * (W/nf + 0.18u)' nrd='0.18u / W' nrs='0.18u / W' sa=0 sb=0 sd=0 m=16 par=16
XM11 out outs1 net1 vss nfet_03v3 L=4u W=4u nf=1 ad='int((nf+1)/2) * W/nf * 0.18u' as='int((nf+2)/2) * W/nf * 0.18u' pd='2*int((nf+1)/2) * (W/nf + 0.18u)'
+ ps='2*int((nf+2)/2) * (W/nf + 0.18u)' nrd='0.18u / W' nrs='0.18u / W' sa=0 sb=0 sd=0 m=4 par=4
XM23 vss vbn2 vss vss nfet_03v3 L=4u W=2u nf=1 ad='int((nf+1)/2) * W/nf * 0.18u' as='int((nf+2)/2) * W/nf * 0.18u' pd='2*int((nf+1)/2) * (W/nf + 0.18u)'
+ ps='2*int((nf+2)/2) * (W/nf + 0.18u)' nrd='0.18u / W' nrs='0.18u / W' sa=0 sb=0 sd=0 m=4 par=4
XM24 vss vss vss vss nfet_03v3 L=1u W=1u nf=1 ad='int((nf+1)/2) * W/nf * 0.18u' as='int((nf+2)/2) * W/nf * 0.18u' pd='2*int((nf+1)/2) * (W/nf + 0.18u)'
+ ps='2*int((nf+2)/2) * (W/nf + 0.18u)' nrd='0.18u / W' nrs='0.18u / W' sa=0 sb=0 sd=0 m=12 par=12
XM25 bias ena vdd vdd pfet_03v3 L=0.28u W=1.0u nf=1 ad='int((nf+1)/2) * W/nf * 0.18u' as='int((nf+2)/2) * W/nf * 0.18u' pd='2*int((nf+1)/2) * (W/nf + 0.18u)'
+ ps='2*int((nf+2)/2) * (W/nf + 0.18u)' nrd='0.18u / W' nrs='0.18u / W' sa=0 sb=0 sd=0 m=1 par=1
XM26 outs1 ena vdd vdd pfet_03v3 L=0.28u W=0.5u nf=1 ad='int((nf+1)/2) * W/nf * 0.18u' as='int((nf+2)/2) * W/nf * 0.18u' pd='2*int((nf+1)/2) * (W/nf + 0.18u)'
+ ps='2*int((nf+2)/2) * (W/nf + 0.18u)' nrd='0.18u / W' nrs='0.18u / W' sa=0 sb=0 sd=0 m=4 par=4
XM27 net1 ena vss vss nfet_03v3 L=0.28u W=4u nf=1 ad='int((nf+1)/2) * W/nf * 0.18u' as='int((nf+2)/2) * W/nf * 0.18u' pd='2*int((nf+1)/2) * (W/nf + 0.18u)'
+ ps='2*int((nf+2)/2) * (W/nf + 0.18u)' nrd='0.18u / W' nrs='0.18u / W' sa=0 sb=0 sd=0 m=4 par=4
.ends

* expanding   symbol:  bg_res.sym # of pins=11
** sym_path: /home/tim/gits/gf180mcu_ocd_chipalooza/dependencies/gf180mcu_ocd_ip__biasgen/xschem/bg_res.sym
** sch_path: /home/tim/gits/gf180mcu_ocd_chipalooza/dependencies/gf180mcu_ocd_ip__biasgen/xschem/bg_res.sch
.subckt bg_res b a d c vss f h k e g j
*.PININFO a:I b:I c:O d:O vss:B f:O e:I h:O g:I k:O j:I
XR23 net4 a vss ppolyf_u_1k r_width=1.0e-6 r_length=6.88e-6 m=1
XR1 net3 b vss ppolyf_u_1k r_width=1.0e-6 r_length=6.88e-6 m=1
XR2 net2 net3 vss ppolyf_u_1k r_width=1.0e-6 r_length=6.88e-6 m=1
XR3 net7 net2 vss ppolyf_u_1k r_width=1.0e-6 r_length=6.88e-6 m=1
XR4 net1 net4 vss ppolyf_u_1k r_width=1.0e-6 r_length=6.88e-6 m=1
XR5 net8 net1 vss ppolyf_u_1k r_width=1.0e-6 r_length=6.88e-6 m=1
XR6 net5 net8 vss ppolyf_u_1k r_width=1.0e-6 r_length=6.88e-6 m=1
XR7 net12 net5 vss ppolyf_u_1k r_width=1.0e-6 r_length=6.88e-6 m=1
XR8 net9 net12 vss ppolyf_u_1k r_width=1.0e-6 r_length=6.88e-6 m=1
XR9 net6 net7 vss ppolyf_u_1k r_width=1.0e-6 r_length=6.88e-6 m=1
XR10 net11 net6 vss ppolyf_u_1k r_width=1.0e-6 r_length=6.88e-6 m=1
XR11 net10 net11 vss ppolyf_u_1k r_width=1.0e-6 r_length=6.88e-6 m=1
XR12 f e vss ppolyf_u_1k r_width=1.0e-6 r_length=6.88e-6 m=1
XR13 h g vss ppolyf_u_1k r_width=1.0e-6 r_length=6.88e-6 m=1
XR14 k j vss ppolyf_u_1k r_width=1.0e-6 r_length=6.88e-6 m=1
XR15 net14 net9 vss ppolyf_u_1k r_width=1.0e-6 r_length=6.88e-6 m=1
XR16 net13 net10 vss ppolyf_u_1k r_width=1.0e-6 r_length=6.88e-6 m=1
XR17 net15 net13 vss ppolyf_u_1k r_width=1.0e-6 r_length=6.88e-6 m=1
XR18 net17 net15 vss ppolyf_u_1k r_width=1.0e-6 r_length=6.88e-6 m=1
XR19 net16 net14 vss ppolyf_u_1k r_width=1.0e-6 r_length=6.88e-6 m=1
XR20 net18 net16 vss ppolyf_u_1k r_width=1.0e-6 r_length=6.88e-6 m=1
XR21 net20 net18 vss ppolyf_u_1k r_width=1.0e-6 r_length=6.88e-6 m=1
XR22 net19 net17 vss ppolyf_u_1k r_width=1.0e-6 r_length=6.88e-6 m=1
XR24 net21 net19 vss ppolyf_u_1k r_width=1.0e-6 r_length=6.88e-6 m=1
XR25 net22 net20 vss ppolyf_u_1k r_width=1.0e-6 r_length=6.88e-6 m=1
XR26 c net22 vss ppolyf_u_1k r_width=1.0e-6 r_length=6.88e-6 m=1
XR27 d net21 vss ppolyf_u_1k r_width=1.0e-6 r_length=6.88e-6 m=1
.ends

* expanding   symbol:  bg_trim.sym # of pins=4
** sym_path: /home/tim/gits/gf180mcu_ocd_chipalooza/dependencies/gf180mcu_ocd_ip__biasgen/xschem/bg_trim.sym
** sch_path: /home/tim/gits/gf180mcu_ocd_chipalooza/dependencies/gf180mcu_ocd_ip__biasgen/xschem/bg_trim.sch
.subckt bg_trim top bot ctrl[15] ctrl[14] ctrl[13] ctrl[12] ctrl[11] ctrl[10] ctrl[9] ctrl[8] ctrl[7] ctrl[6] ctrl[5] ctrl[4]
+ ctrl[3] ctrl[2] ctrl[1] ctrl[0] vss
*.PININFO vss:B ctrl[15:0]:I bot:B top:B
XM17 vss vss vss vss nfet_03v3 L=0.5u W=2.0u nf=1 ad='int((nf+1)/2) * W/nf * 0.18u' as='int((nf+2)/2) * W/nf * 0.18u' pd='2*int((nf+1)/2) * (W/nf + 0.18u)'
+ ps='2*int((nf+2)/2) * (W/nf + 0.18u)' nrd='0.18u / W' nrs='0.18u / W' sa=0 sb=0 sd=0 m=1 par=1
XM1 top ctrl[15] bot vss nfet_03v3 L=0.5u W=2.0u nf=1 ad='int((nf+1)/2) * W/nf * 0.18u' as='int((nf+2)/2) * W/nf * 0.18u' pd='2*int((nf+1)/2) * (W/nf + 0.18u)'
+ ps='2*int((nf+2)/2) * (W/nf + 0.18u)' nrd='0.18u / W' nrs='0.18u / W' sa=0 sb=0 sd=0 m=1 par=1
XM2 net12 ctrl[14] bot vss nfet_03v3 L=0.5u W=2.0u nf=1 ad='int((nf+1)/2) * W/nf * 0.18u' as='int((nf+2)/2) * W/nf * 0.18u' pd='2*int((nf+1)/2) * (W/nf + 0.18u)'
+ ps='2*int((nf+2)/2) * (W/nf + 0.18u)' nrd='0.18u / W' nrs='0.18u / W' sa=0 sb=0 sd=0 m=1 par=1
XM3 net11 ctrl[13] bot vss nfet_03v3 L=0.5u W=2.0u nf=1 ad='int((nf+1)/2) * W/nf * 0.18u' as='int((nf+2)/2) * W/nf * 0.18u' pd='2*int((nf+1)/2) * (W/nf + 0.18u)'
+ ps='2*int((nf+2)/2) * (W/nf + 0.18u)' nrd='0.18u / W' nrs='0.18u / W' sa=0 sb=0 sd=0 m=1 par=1
XM4 net9 ctrl[12] bot vss nfet_03v3 L=0.5u W=2.0u nf=1 ad='int((nf+1)/2) * W/nf * 0.18u' as='int((nf+2)/2) * W/nf * 0.18u' pd='2*int((nf+1)/2) * (W/nf + 0.18u)'
+ ps='2*int((nf+2)/2) * (W/nf + 0.18u)' nrd='0.18u / W' nrs='0.18u / W' sa=0 sb=0 sd=0 m=1 par=1
XM5 net10 ctrl[11] bot vss nfet_03v3 L=0.5u W=2.0u nf=1 ad='int((nf+1)/2) * W/nf * 0.18u' as='int((nf+2)/2) * W/nf * 0.18u' pd='2*int((nf+1)/2) * (W/nf + 0.18u)'
+ ps='2*int((nf+2)/2) * (W/nf + 0.18u)' nrd='0.18u / W' nrs='0.18u / W' sa=0 sb=0 sd=0 m=1 par=1
XM6 net15 ctrl[10] bot vss nfet_03v3 L=0.5u W=2.0u nf=1 ad='int((nf+1)/2) * W/nf * 0.18u' as='int((nf+2)/2) * W/nf * 0.18u' pd='2*int((nf+1)/2) * (W/nf + 0.18u)'
+ ps='2*int((nf+2)/2) * (W/nf + 0.18u)' nrd='0.18u / W' nrs='0.18u / W' sa=0 sb=0 sd=0 m=1 par=1
XM7 net14 ctrl[9] bot vss nfet_03v3 L=0.5u W=2.0u nf=1 ad='int((nf+1)/2) * W/nf * 0.18u' as='int((nf+2)/2) * W/nf * 0.18u' pd='2*int((nf+1)/2) * (W/nf + 0.18u)'
+ ps='2*int((nf+2)/2) * (W/nf + 0.18u)' nrd='0.18u / W' nrs='0.18u / W' sa=0 sb=0 sd=0 m=1 par=1
XM8 net13 ctrl[8] bot vss nfet_03v3 L=0.5u W=2.0u nf=1 ad='int((nf+1)/2) * W/nf * 0.18u' as='int((nf+2)/2) * W/nf * 0.18u' pd='2*int((nf+1)/2) * (W/nf + 0.18u)'
+ ps='2*int((nf+2)/2) * (W/nf + 0.18u)' nrd='0.18u / W' nrs='0.18u / W' sa=0 sb=0 sd=0 m=1 par=1
XM9 net8 ctrl[7] bot vss nfet_03v3 L=0.5u W=2.0u nf=1 ad='int((nf+1)/2) * W/nf * 0.18u' as='int((nf+2)/2) * W/nf * 0.18u' pd='2*int((nf+1)/2) * (W/nf + 0.18u)'
+ ps='2*int((nf+2)/2) * (W/nf + 0.18u)' nrd='0.18u / W' nrs='0.18u / W' sa=0 sb=0 sd=0 m=1 par=1
XM10 net7 ctrl[6] bot vss nfet_03v3 L=0.5u W=2.0u nf=1 ad='int((nf+1)/2) * W/nf * 0.18u' as='int((nf+2)/2) * W/nf * 0.18u' pd='2*int((nf+1)/2) * (W/nf + 0.18u)'
+ ps='2*int((nf+2)/2) * (W/nf + 0.18u)' nrd='0.18u / W' nrs='0.18u / W' sa=0 sb=0 sd=0 m=1 par=1
XM11 net6 ctrl[5] bot vss nfet_03v3 L=0.5u W=2.0u nf=1 ad='int((nf+1)/2) * W/nf * 0.18u' as='int((nf+2)/2) * W/nf * 0.18u' pd='2*int((nf+1)/2) * (W/nf + 0.18u)'
+ ps='2*int((nf+2)/2) * (W/nf + 0.18u)' nrd='0.18u / W' nrs='0.18u / W' sa=0 sb=0 sd=0 m=1 par=1
XM12 net5 ctrl[4] bot vss nfet_03v3 L=0.5u W=2.0u nf=1 ad='int((nf+1)/2) * W/nf * 0.18u' as='int((nf+2)/2) * W/nf * 0.18u' pd='2*int((nf+1)/2) * (W/nf + 0.18u)'
+ ps='2*int((nf+2)/2) * (W/nf + 0.18u)' nrd='0.18u / W' nrs='0.18u / W' sa=0 sb=0 sd=0 m=1 par=1
XM13 net4 ctrl[3] bot vss nfet_03v3 L=0.5u W=2.0u nf=1 ad='int((nf+1)/2) * W/nf * 0.18u' as='int((nf+2)/2) * W/nf * 0.18u' pd='2*int((nf+1)/2) * (W/nf + 0.18u)'
+ ps='2*int((nf+2)/2) * (W/nf + 0.18u)' nrd='0.18u / W' nrs='0.18u / W' sa=0 sb=0 sd=0 m=1 par=1
XM14 net3 ctrl[2] bot vss nfet_03v3 L=0.5u W=2.0u nf=1 ad='int((nf+1)/2) * W/nf * 0.18u' as='int((nf+2)/2) * W/nf * 0.18u' pd='2*int((nf+1)/2) * (W/nf + 0.18u)'
+ ps='2*int((nf+2)/2) * (W/nf + 0.18u)' nrd='0.18u / W' nrs='0.18u / W' sa=0 sb=0 sd=0 m=1 par=1
XM15 net2 ctrl[1] bot vss nfet_03v3 L=0.5u W=2.0u nf=1 ad='int((nf+1)/2) * W/nf * 0.18u' as='int((nf+2)/2) * W/nf * 0.18u' pd='2*int((nf+1)/2) * (W/nf + 0.18u)'
+ ps='2*int((nf+2)/2) * (W/nf + 0.18u)' nrd='0.18u / W' nrs='0.18u / W' sa=0 sb=0 sd=0 m=1 par=1
XM16 net1 ctrl[0] bot vss nfet_03v3 L=0.5u W=2.0u nf=1 ad='int((nf+1)/2) * W/nf * 0.18u' as='int((nf+2)/2) * W/nf * 0.18u' pd='2*int((nf+1)/2) * (W/nf + 0.18u)'
+ ps='2*int((nf+2)/2) * (W/nf + 0.18u)' nrd='0.18u / W' nrs='0.18u / W' sa=0 sb=0 sd=0 m=1 par=1
XR19 net12 top vss ppolyf_u r_width=1e-6 r_length=2.2e-6 m=6
XR1 net11 net12 vss ppolyf_u r_width=1e-6 r_length=2.2e-6 m=6
XR2 net9 net11 vss ppolyf_u r_width=1e-6 r_length=2.2e-6 m=6
XR3 net10 net9 vss ppolyf_u r_width=1e-6 r_length=2.2e-6 m=6
XR4 net15 net10 vss ppolyf_u r_width=1e-6 r_length=2.2e-6 m=6
XR5 net14 net15 vss ppolyf_u r_width=1e-6 r_length=2.2e-6 m=6
XR6 net13 net14 vss ppolyf_u r_width=1e-6 r_length=2.2e-6 m=6
XR7 net8 net13 vss ppolyf_u r_width=1e-6 r_length=2.2e-6 m=6
XR8 net7 net8 vss ppolyf_u r_width=1e-6 r_length=2.2e-6 m=6
XR9 net6 net7 vss ppolyf_u r_width=1e-6 r_length=2.2e-6 m=6
XR10 net5 net6 vss ppolyf_u r_width=1e-6 r_length=2.2e-6 m=6
XR11 net4 net5 vss ppolyf_u r_width=1e-6 r_length=2.2e-6 m=6
XR12 net3 net4 vss ppolyf_u r_width=1e-6 r_length=2.2e-6 m=6
XR13 net2 net3 vss ppolyf_u r_width=1e-6 r_length=2.2e-6 m=6
XR14 net1 net2 vss ppolyf_u r_width=1e-6 r_length=2.2e-6 m=6
XR15 bot net1 vss ppolyf_u r_width=1e-6 r_length=2.2e-6 m=6
XR16 vss vss vss ppolyf_u r_width=1e-6 r_length=2.2e-6 m=1
XR17 top top top ppolyf_u r_width=1e-6 r_length=2.2e-6 m=1
.ends

* expanding   symbol:  se_folded_cascode_p.sym # of pins=7
** sym_path: /home/tim/gits/gf180mcu_ocd_chipalooza/dependencies/gf180mcu_ocd_ip__biasgen/xschem/se_folded_cascode_p.sym
** sch_path: /home/tim/gits/gf180mcu_ocd_chipalooza/dependencies/gf180mcu_ocd_ip__biasgen/xschem/se_folded_cascode_p.sch
.subckt se_folded_cascode_p vdd out inp inn vss bias ena
*.PININFO inn:I inp:I out:O bias:B vdd:B vss:B ena:I
XM14 vbp1 vbp1 vdd vdd pfet_03v3 L=1u W=1u nf=1 ad='int((nf+1)/2) * W/nf * 0.18u' as='int((nf+2)/2) * W/nf * 0.18u' pd='2*int((nf+1)/2) * (W/nf + 0.18u)'
+ ps='2*int((nf+2)/2) * (W/nf + 0.18u)' nrd='0.18u / W' nrs='0.18u / W' sa=0 sb=0 sd=0 m=4 par=4
XM15 bias bias vbp1 vdd pfet_03v3 L=0.5u W=2u nf=1 ad='int((nf+1)/2) * W/nf * 0.18u' as='int((nf+2)/2) * W/nf * 0.18u' pd='2*int((nf+1)/2) * (W/nf + 0.18u)'
+ ps='2*int((nf+2)/2) * (W/nf + 0.18u)' nrd='0.18u / W' nrs='0.18u / W' sa=0 sb=0 sd=0 m=8 par=8
XM17 vbn2 vbp1 vdd vdd pfet_03v3 L=1u W=1u nf=1 ad='int((nf+1)/2) * W/nf * 0.18u' as='int((nf+2)/2) * W/nf * 0.18u' pd='2*int((nf+1)/2) * (W/nf + 0.18u)'
+ ps='2*int((nf+2)/2) * (W/nf + 0.18u)' nrd='0.18u / W' nrs='0.18u / W' sa=0 sb=0 sd=0 m=4 par=4
XM18 vbn2 vbn2 vbn1 vss nfet_03v3 L=4u W=1u nf=1 ad='int((nf+1)/2) * W/nf * 0.18u' as='int((nf+2)/2) * W/nf * 0.18u' pd='2*int((nf+1)/2) * (W/nf + 0.18u)'
+ ps='2*int((nf+2)/2) * (W/nf + 0.18u)' nrd='0.18u / W' nrs='0.18u / W' sa=0 sb=0 sd=0 m=4 par=4
XM19 vbn1 vbn1 vss vss nfet_03v3 L=1u W=1u nf=1 ad='int((nf+1)/2) * W/nf * 0.18u' as='int((nf+2)/2) * W/nf * 0.18u' pd='2*int((nf+1)/2) * (W/nf + 0.18u)'
+ ps='2*int((nf+2)/2) * (W/nf + 0.18u)' nrd='0.18u / W' nrs='0.18u / W' sa=0 sb=0 sd=0 m=4 par=4
XM20 diff vbp1 vdd vdd pfet_03v3 L=1u W=1u nf=1 ad='int((nf+1)/2) * W/nf * 0.18u' as='int((nf+2)/2) * W/nf * 0.18u' pd='2*int((nf+1)/2) * (W/nf + 0.18u)'
+ ps='2*int((nf+2)/2) * (W/nf + 0.18u)' nrd='0.18u / W' nrs='0.18u / W' sa=0 sb=0 sd=0 m=16 par=16
XM1 out1n inp diff vdd pfet_03v3 L=1u W=4u nf=1 ad='int((nf+1)/2) * W/nf * 0.18u' as='int((nf+2)/2) * W/nf * 0.18u' pd='2*int((nf+1)/2) * (W/nf + 0.18u)'
+ ps='2*int((nf+2)/2) * (W/nf + 0.18u)' nrd='0.18u / W' nrs='0.18u / W' sa=0 sb=0 sd=0 m=8 par=8
XM2 out1p inn diff vdd pfet_03v3 L=1u W=4u nf=1 ad='int((nf+1)/2) * W/nf * 0.18u' as='int((nf+2)/2) * W/nf * 0.18u' pd='2*int((nf+1)/2) * (W/nf + 0.18u)'
+ ps='2*int((nf+2)/2) * (W/nf + 0.18u)' nrd='0.18u / W' nrs='0.18u / W' sa=0 sb=0 sd=0 m=8 par=8
XM3 nd10 mirr vdd vdd pfet_03v3 L=4u W=2u nf=1 ad='int((nf+1)/2) * W/nf * 0.18u' as='int((nf+2)/2) * W/nf * 0.18u' pd='2*int((nf+1)/2) * (W/nf + 0.18u)'
+ ps='2*int((nf+2)/2) * (W/nf + 0.18u)' nrd='0.18u / W' nrs='0.18u / W' sa=0 sb=0 sd=0 m=8 par=8
XM8 nd11 mirr vdd vdd pfet_03v3 L=4u W=2u nf=1 ad='int((nf+1)/2) * W/nf * 0.18u' as='int((nf+2)/2) * W/nf * 0.18u' pd='2*int((nf+1)/2) * (W/nf + 0.18u)'
+ ps='2*int((nf+2)/2) * (W/nf + 0.18u)' nrd='0.18u / W' nrs='0.18u / W' sa=0 sb=0 sd=0 m=8 par=8
XM9 out bias nd11 vdd pfet_03v3 L=0.5u W=2u nf=1 ad='int((nf+1)/2) * W/nf * 0.18u' as='int((nf+2)/2) * W/nf * 0.18u' pd='2*int((nf+1)/2) * (W/nf + 0.18u)'
+ ps='2*int((nf+2)/2) * (W/nf + 0.18u)' nrd='0.18u / W' nrs='0.18u / W' sa=0 sb=0 sd=0 m=16 par=16
XM10 mirr bias nd10 vdd pfet_03v3 L=0.5u W=2u nf=1 ad='int((nf+1)/2) * W/nf * 0.18u' as='int((nf+2)/2) * W/nf * 0.18u' pd='2*int((nf+1)/2) * (W/nf + 0.18u)'
+ ps='2*int((nf+2)/2) * (W/nf + 0.18u)' nrd='0.18u / W' nrs='0.18u / W' sa=0 sb=0 sd=0 m=16 par=16
XM4 out vbn2 out1p vss nfet_03v3 L=4u W=1u nf=1 ad='int((nf+1)/2) * W/nf * 0.18u' as='int((nf+2)/2) * W/nf * 0.18u' pd='2*int((nf+1)/2) * (W/nf + 0.18u)'
+ ps='2*int((nf+2)/2) * (W/nf + 0.18u)' nrd='0.18u / W' nrs='0.18u / W' sa=0 sb=0 sd=0 m=8 par=8
XM5 out1p vbn1 vss vss nfet_03v3 L=1u W=1u nf=1 ad='int((nf+1)/2) * W/nf * 0.18u' as='int((nf+2)/2) * W/nf * 0.18u' pd='2*int((nf+1)/2) * (W/nf + 0.18u)'
+ ps='2*int((nf+2)/2) * (W/nf + 0.18u)' nrd='0.18u / W' nrs='0.18u / W' sa=0 sb=0 sd=0 m=16 par=16
XM6 out1n vbn1 vss vss nfet_03v3 L=1u W=1u nf=1 ad='int((nf+1)/2) * W/nf * 0.18u' as='int((nf+2)/2) * W/nf * 0.18u' pd='2*int((nf+1)/2) * (W/nf + 0.18u)'
+ ps='2*int((nf+2)/2) * (W/nf + 0.18u)' nrd='0.18u / W' nrs='0.18u / W' sa=0 sb=0 sd=0 m=16 par=16
XM7 mirr vbn2 out1n vss nfet_03v3 L=4u W=1u nf=1 ad='int((nf+1)/2) * W/nf * 0.18u' as='int((nf+2)/2) * W/nf * 0.18u' pd='2*int((nf+1)/2) * (W/nf + 0.18u)'
+ ps='2*int((nf+2)/2) * (W/nf + 0.18u)' nrd='0.18u / W' nrs='0.18u / W' sa=0 sb=0 sd=0 m=8 par=8
XM11 vdd vdd vdd vdd pfet_03v3 L=1u W=4u nf=1 ad='int((nf+1)/2) * W/nf * 0.18u' as='int((nf+2)/2) * W/nf * 0.18u' pd='2*int((nf+1)/2) * (W/nf + 0.18u)'
+ ps='2*int((nf+2)/2) * (W/nf + 0.18u)' nrd='0.18u / W' nrs='0.18u / W' sa=0 sb=0 sd=0 m=8 par=8
XM12 vss vss vss vss nfet_03v3 L=1u W=1u nf=1 ad='int((nf+1)/2) * W/nf * 0.18u' as='int((nf+2)/2) * W/nf * 0.18u' pd='2*int((nf+1)/2) * (W/nf + 0.18u)'
+ ps='2*int((nf+2)/2) * (W/nf + 0.18u)' nrd='0.18u / W' nrs='0.18u / W' sa=0 sb=0 sd=0 m=16 par=16
XM13 vdd vdd vdd vdd pfet_03v3 L=1u W=1u nf=2 ad='int((nf+1)/2) * W/nf * 0.18u' as='int((nf+2)/2) * W/nf * 0.18u' pd='2*int((nf+1)/2) * (W/nf + 0.18u)'
+ ps='2*int((nf+2)/2) * (W/nf + 0.18u)' nrd='0.18u / W' nrs='0.18u / W' sa=0 sb=0 sd=0 m=8 par=8
XM21 bias ena vdd vdd pfet_03v3 L=0.5u W=1u nf=1 ad='int((nf+1)/2) * W/nf * 0.18u' as='int((nf+2)/2) * W/nf * 0.18u' pd='2*int((nf+1)/2) * (W/nf + 0.18u)'
+ ps='2*int((nf+2)/2) * (W/nf + 0.18u)' nrd='0.18u / W' nrs='0.18u / W' sa=0 sb=0 sd=0 m=1 par=1
.ends

* expanding   symbol:  level_shift.sym # of pins=3
** sym_path: /home/tim/gits/gf180mcu_ocd_chipalooza/dependencies/gf180mcu_ocd_ip__biasgen/xschem/level_shift.sym
** sch_path: /home/tim/gits/gf180mcu_ocd_chipalooza/dependencies/gf180mcu_ocd_ip__biasgen/xschem/level_shift.sch
.subckt level_shift in_n in_p out vdd vss
*.PININFO in_n:I in_p:I out:O
XM9 net1 S1_N vdd vdd pfet_03v3 L=0.5u W=1u nf=1 ad='int((nf+1)/2) * W/nf * 0.18u' as='int((nf+2)/2) * W/nf * 0.18u' pd='2*int((nf+1)/2) * (W/nf + 0.18u)'
+ ps='2*int((nf+2)/2) * (W/nf + 0.18u)' nrd='0.18u / W' nrs='0.18u / W' sa=0 sb=0 sd=0 m=2 par=2
XM2 S1_N net1 vdd vdd pfet_03v3 L=0.5u W=1u nf=1 ad='int((nf+1)/2) * W/nf * 0.18u' as='int((nf+2)/2) * W/nf * 0.18u' pd='2*int((nf+1)/2) * (W/nf + 0.18u)'
+ ps='2*int((nf+2)/2) * (W/nf + 0.18u)' nrd='0.18u / W' nrs='0.18u / W' sa=0 sb=0 sd=0 m=2 par=2
XM4 S2_N S1_N vdd vdd pfet_03v3 L=0.5u W=2u nf=1 ad='int((nf+1)/2) * W/nf * 0.18u' as='int((nf+2)/2) * W/nf * 0.18u' pd='2*int((nf+1)/2) * (W/nf + 0.18u)'
+ ps='2*int((nf+2)/2) * (W/nf + 0.18u)' nrd='0.18u / W' nrs='0.18u / W' sa=0 sb=0 sd=0 m=2 par=2
XM5 out S2_N vdd vdd pfet_03v3 L=0.5u W=2u nf=1 ad='int((nf+1)/2) * W/nf * 0.18u' as='int((nf+2)/2) * W/nf * 0.18u' pd='2*int((nf+1)/2) * (W/nf + 0.18u)'
+ ps='2*int((nf+2)/2) * (W/nf + 0.18u)' nrd='0.18u / W' nrs='0.18u / W' sa=0 sb=0 sd=0 m=2 par=2
XM7 net1 in_p vss vss nfet_03v3 L=0.5u W=4u nf=1 ad='int((nf+1)/2) * W/nf * 0.18u' as='int((nf+2)/2) * W/nf * 0.18u' pd='2*int((nf+1)/2) * (W/nf + 0.18u)'
+ ps='2*int((nf+2)/2) * (W/nf + 0.18u)' nrd='0.18u / W' nrs='0.18u / W' sa=0 sb=0 sd=0 m=2 par=2
XM1 S1_N in_n vss vss nfet_03v3 L=0.5u W=4u nf=1 ad='int((nf+1)/2) * W/nf * 0.18u' as='int((nf+2)/2) * W/nf * 0.18u' pd='2*int((nf+1)/2) * (W/nf + 0.18u)'
+ ps='2*int((nf+2)/2) * (W/nf + 0.18u)' nrd='0.18u / W' nrs='0.18u / W' sa=0 sb=0 sd=0 m=2 par=2
XM3 S2_N S1_N vss vss nfet_03v3 L=0.5u W=1u nf=1 ad='int((nf+1)/2) * W/nf * 0.18u' as='int((nf+2)/2) * W/nf * 0.18u' pd='2*int((nf+1)/2) * (W/nf + 0.18u)'
+ ps='2*int((nf+2)/2) * (W/nf + 0.18u)' nrd='0.18u / W' nrs='0.18u / W' sa=0 sb=0 sd=0 m=2 par=2
XM6 out S2_N vss vss nfet_03v3 L=0.5u W=1u nf=1 ad='int((nf+1)/2) * W/nf * 0.18u' as='int((nf+2)/2) * W/nf * 0.18u' pd='2*int((nf+1)/2) * (W/nf + 0.18u)'
+ ps='2*int((nf+2)/2) * (W/nf + 0.18u)' nrd='0.18u / W' nrs='0.18u / W' sa=0 sb=0 sd=0 m=2 par=2
.ends
